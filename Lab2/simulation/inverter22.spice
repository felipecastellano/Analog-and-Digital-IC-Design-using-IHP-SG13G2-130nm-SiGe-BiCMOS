** sch_path: /home/fcastellanos/Documents/SEED_Bootcamp_ihp/Modulo_Analogico/Lab2/inverter22.sch
.subckt inverter22 VDD vin Vout VSS
*.PININFO vin:I Vout:B VDD:B VSS:B
M1 Vout vin VSS VSS sg13_lv_nmos w=1u l=1u ng=1 m=1
M2 Vout vin VDD VDD sg13_lv_pmos w=3u l=1u ng=1 m=1
.ends
.end
