** sch_path: /home/fcastellanos/Documents/SEED_Bootcamp_ihp/Modulo_Analogico/Lab2/3_stage_RO.sch
.subckt 3_stage_RO VDD VSS n1
*.PININFO VDD:B VSS:B n1:B
x1 n1 VDD VSS n2 inverter
x2 n2 VDD VSS n3 inverter
x3 n3 VDD VSS n1 inverter
.ends

* expanding   symbol:  /home/fcastellanos/Documents/SEED_Bootcamp_ihp/Modulo_Analogico/Lab2/inverter.sym # of pins=4
** sym_path: /home/fcastellanos/Documents/SEED_Bootcamp_ihp/Modulo_Analogico/Lab2/inverter.sym
** sch_path: /home/fcastellanos/Documents/SEED_Bootcamp_ihp/Modulo_Analogico/Lab2/inverter.sch
.subckt inverter Vin VDD VSS Vout
*.PININFO Vin:I VDD:B VSS:B Vout:B
M1 Vout Vin VSS VSS sg13_lv_nmos w=1u l=1u ng=1 m=1
M2 Vout Vin VDD VDD sg13_lv_pmos w=3u l=1u ng=1 m=1
.ends

.end
