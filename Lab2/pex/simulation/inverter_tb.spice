** sch_path: /home/fcastellanos/Documents/SEED_Bootcamp_ihp/Modulo_Analogico/Lab2/pex/inverter_tb.sch
**.subckt inverter_tb
C1 Vout VSS 100f m=1
V1 VSS GND 0
V2 VDD VSS 1.5
Vin Vin VSS 0
x1 VDD Vin Vout VSS inverter22
**** begin user architecture code

.include /home/fcastellanos/Documents/SEED_Bootcamp_ihp/Modulo_Analogico/Lab2/pex/inverter22.spice
.dc Vin 0 1.5 0.01
.save all

.lib cornerMOSlv.lib mos_tt

**** end user architecture code
**.ends
.GLOBAL GND
.end
