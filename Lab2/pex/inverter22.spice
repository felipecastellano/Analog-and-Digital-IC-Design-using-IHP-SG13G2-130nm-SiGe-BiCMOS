* NGSPICE file created from inverter22.ext - technology: ihp-sg13g2

.subckt inverter22 VDD vin Vout VSS
X0 Vout.t0 vin.t0 VDD.t1 VDD.t0 sg13_lv_pmos ad=1.02p pd=6.68u as=1.02p ps=6.68u w=3u l=1u
X1 Vout.t1 vin.t1 VSS.t1 VSS.t0 sg13_lv_nmos ad=0.34p pd=2.68u as=0.34p ps=2.68u w=1u l=1u
R0 vin vin.t0 7.55356
R1 vin vin.t1 7.53091
R2 VDD.n0 VDD.t0 11.343
R3 VDD.n0 VDD.t1 2.47495
R4 VDD VDD.n0 0.0134322
R5 Vout Vout.t1 5.84325
R6 Vout Vout.t0 2.43963
R7 VSS.n2 VSS.t0 1465.12
R8 VSS VSS.n0 17.0033
R9 VSS.n2 VSS.n0 8.501
R10 VSS.n3 VSS.n1 8.48826
R11 VSS.n5 VSS.n4 8.48776
R12 VSS.n1 VSS.t1 5.88997
R13 VSS.n3 VSS.n2 5.66767
R14 VSS.n5 VSS.n1 0.107517
R15 VSS VSS.n5 0.0781927
R16 VSS.n4 VSS.n3 0.001
R17 VSS.n4 VSS.n0 0.001
C0 VDD Vout 0.14304f
C1 VDD vin 0.46598f
C2 Vout vin 0.18298f
C3 Vout VSS 0.39118f
C4 vin VSS 0.87078f
C5 VDD VSS 0.31343f
.ends
