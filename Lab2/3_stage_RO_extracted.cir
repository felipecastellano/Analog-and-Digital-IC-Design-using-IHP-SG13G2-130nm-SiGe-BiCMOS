* Extracted by KLayout with SG13G2 LVS runset on : 05/12/2025 07:03

.SUBCKT 3_stage_RO
M$1 \$1 \$2 \$3 \$1 sg13_lv_nmos L=1u W=1u AS=0.34p AD=0.34p PS=2.68u PD=2.68u
M$2 \$1 \$3 \$4 \$1 sg13_lv_nmos L=1u W=1u AS=0.34p AD=0.34p PS=2.68u PD=2.68u
M$3 \$1 \$4 \$2 \$1 sg13_lv_nmos L=1u W=1u AS=0.34p AD=0.34p PS=2.68u PD=2.68u
M$4 \$8 \$2 \$3 \$8 sg13_lv_pmos L=1u W=3u AS=1.02p AD=1.02p PS=6.68u PD=6.68u
M$5 \$8 \$3 \$4 \$8 sg13_lv_pmos L=1u W=3u AS=1.02p AD=1.02p PS=6.68u PD=6.68u
M$6 \$8 \$4 \$2 \$8 sg13_lv_pmos L=1u W=3u AS=1.02p AD=1.02p PS=6.68u PD=6.68u
.ENDS 3_stage_RO
